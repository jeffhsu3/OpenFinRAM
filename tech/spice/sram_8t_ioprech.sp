* OpenFinRAM ASAP7 8T port-specific IO/precharge wrappers.
*
* Both cells wrap the published differential iocolgrp_sram_6t122_v2 core.
* Port A lands the four-row 8T array on M2; port B uses an M4-to-M2 pitch
* adapter.  The pin order matches SpiceTemplates::get_ioprech_8t_{a,b}().

.SUBCKT ioprech_sram_8t_a
+ WRENAN_A WRENA_A SAE_A SAPRECHN_A OEB_OUT_A OE_OUT_A D_A Q_A
+ BLTN_A[0] BLTN_A[1] BLTN_A[2] BLTN_A[3]
+ BLT_A[0] BLT_A[1] BLT_A[2] BLT_A[3]
+ BLBN_A[0] BLBN_A[1] BLBN_A[2] BLBN_A[3]
+ BLB_A[0] BLB_A[1] BLB_A[2] BLB_A[3]
+ BLPRECHTN_A BLPRECHBN_A
+ YSELTN_A[0] YSELTN_A[1] YSELTN_A[2] YSELTN_A[3]
+ YSELT_A[0] YSELT_A[1] YSELT_A[2] YSELT_A[3]
+ YSELBN_A[0] YSELBN_A[1] YSELBN_A[2] YSELBN_A[3]
+ YSELB_A[0] YSELB_A[1] YSELB_A[2] YSELB_A[3]
+ VDD VSS
XIO_A WRENAN_A WRENA_A SAE_A SAPRECHN_A OEB_OUT_A OE_OUT_A D_A Q_A
+ BLTN_A[0] BLTN_A[1] BLTN_A[2] BLTN_A[3]
+ BLT_A[0] BLT_A[1] BLT_A[2] BLT_A[3]
+ BLBN_A[0] BLBN_A[1] BLBN_A[2] BLBN_A[3]
+ BLB_A[0] BLB_A[1] BLB_A[2] BLB_A[3]
+ BLPRECHTN_A BLPRECHBN_A
+ YSELTN_A[0] YSELTN_A[1] YSELTN_A[2] YSELTN_A[3]
+ YSELT_A[0] YSELT_A[1] YSELT_A[2] YSELT_A[3]
+ YSELBN_A[0] YSELBN_A[1] YSELBN_A[2] YSELBN_A[3]
+ YSELB_A[0] YSELB_A[1] YSELB_A[2] YSELB_A[3]
+ VDD VSS iocolgrp_sram_6t122_v2
.ENDS ioprech_sram_8t_a

.SUBCKT ioprech_sram_8t_b
+ WRENAN_B WRENA_B SAE_B SAPRECHN_B OEB_OUT_B OE_OUT_B D_B Q_B
+ BLTN_B[0] BLTN_B[1] BLTN_B[2] BLTN_B[3]
+ BLT_B[0] BLT_B[1] BLT_B[2] BLT_B[3]
+ BLBN_B[0] BLBN_B[1] BLBN_B[2] BLBN_B[3]
+ BLB_B[0] BLB_B[1] BLB_B[2] BLB_B[3]
+ BLPRECHTN_B BLPRECHBN_B
+ YSELTN_B[0] YSELTN_B[1] YSELTN_B[2] YSELTN_B[3]
+ YSELT_B[0] YSELT_B[1] YSELT_B[2] YSELT_B[3]
+ YSELBN_B[0] YSELBN_B[1] YSELBN_B[2] YSELBN_B[3]
+ YSELB_B[0] YSELB_B[1] YSELB_B[2] YSELB_B[3]
+ VDD VSS
XIO_B WRENAN_B WRENA_B SAE_B SAPRECHN_B OEB_OUT_B OE_OUT_B D_B Q_B
+ BLTN_B[0] BLTN_B[1] BLTN_B[2] BLTN_B[3]
+ BLT_B[0] BLT_B[1] BLT_B[2] BLT_B[3]
+ BLBN_B[0] BLBN_B[1] BLBN_B[2] BLBN_B[3]
+ BLB_B[0] BLB_B[1] BLB_B[2] BLB_B[3]
+ BLPRECHTN_B BLPRECHBN_B
+ YSELTN_B[0] YSELTN_B[1] YSELTN_B[2] YSELTN_B[3]
+ YSELT_B[0] YSELT_B[1] YSELT_B[2] YSELT_B[3]
+ YSELBN_B[0] YSELBN_B[1] YSELBN_B[2] YSELBN_B[3]
+ YSELB_B[0] YSELB_B[1] YSELB_B[2] YSELB_B[3]
+ VDD VSS iocolgrp_sram_6t122_v2
.ENDS ioprech_sram_8t_b
